* Qucs 25.1.2  /home/dponyatov/qucs/lib/qucs/hello_prj/hello.sch
.INCLUDE "/usr/share/qucs-s/xspice_cmlib/include/ngspice_mathfunc.inc"
V1 _net0 0 DC 9
R1 0 _net1  1K tc1=0.0 tc2=0.0
VPr1 _net0 _net1 DC 0
EPr2 Pr2 0 _net1 0 1.0
RPr2Pr2 Pr2 0 1E8
RPr2_net1 _net1 0 1E8

.control

op
print v(Pr2) i(VPr1)   > spice4qucs.dc1.ngspice.dc.print
destroy all
reset

exit
.endc
.END
